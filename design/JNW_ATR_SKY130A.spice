*-------------------------------------------------------------
* JNWATR_PCH_2C1F2 <class 'cicpy.core.layoutcell.LayoutCell'>
*-------------------------------------------------------------
.SUBCKT JNWATR_PCH_2C1F2 D G S B
M1 D G S B sky130_fd_pr__pfet_01v8  l=0.22  nf=2  w=0.96
.ENDS

*-------------------------------------------------------------
* JNWATR_PCH_2CTAP <class 'cicpy.core.layoutcell.LayoutCell'>
*-------------------------------------------------------------
.SUBCKT JNWATR_PCH_2CTAP
.ENDS

*-------------------------------------------------------------
* JNWATR_PCH_2C5F0 <class 'cicpy.core.layoutcell.LayoutCell'>
*-------------------------------------------------------------
.SUBCKT JNWATR_PCH_2C5F0 D G S B
M1 D G S B sky130_fd_pr__pfet_01v8  l=0.94  nf=2  w=0.96
.ENDS

*-------------------------------------------------------------
* JNWATR_PCH_2CTOP <class 'cicpy.core.layoutcell.LayoutCell'>
*-------------------------------------------------------------
.SUBCKT JNWATR_PCH_2CTOP
xa1  JNWATR_PCH_2CTAP
xa2 D G S B JNWATR_PCH_2C1F2
xa3 D G S B JNWATR_PCH_2C5F0
xa4  JNWATR_PCH_2CTAP
.ENDS

*-------------------------------------------------------------
* JNWATR_PCH_4C1F2 <class 'cicpy.core.layoutcell.LayoutCell'>
*-------------------------------------------------------------
.SUBCKT JNWATR_PCH_4C1F2 D G S B
M1 D G S B sky130_fd_pr__pfet_01v8  l=0.22  nf=2  w=1.6
.ENDS

*-------------------------------------------------------------
* JNWATR_PCH_4CTAP <class 'cicpy.core.layoutcell.LayoutCell'>
*-------------------------------------------------------------
.SUBCKT JNWATR_PCH_4CTAP
.ENDS

*-------------------------------------------------------------
* JNWATR_PCH_4C5F0 <class 'cicpy.core.layoutcell.LayoutCell'>
*-------------------------------------------------------------
.SUBCKT JNWATR_PCH_4C5F0 D G S B
M1 D G S B sky130_fd_pr__pfet_01v8  l=0.94  nf=2  w=1.6
.ENDS

*-------------------------------------------------------------
* JNWATR_PCH_4CTOP <class 'cicpy.core.layoutcell.LayoutCell'>
*-------------------------------------------------------------
.SUBCKT JNWATR_PCH_4CTOP
xa1  JNWATR_PCH_4CTAP
xa2 D G S B JNWATR_PCH_4C1F2
xa3 D G S B JNWATR_PCH_4C5F0
xa4  JNWATR_PCH_4CTAP
.ENDS

*-------------------------------------------------------------
* JNWATR_PCH_8C1F2 <class 'cicpy.core.layoutcell.LayoutCell'>
*-------------------------------------------------------------
.SUBCKT JNWATR_PCH_8C1F2 D G S B
M1 D G S B sky130_fd_pr__pfet_01v8  l=0.22  nf=2  w=2.88
.ENDS

*-------------------------------------------------------------
* JNWATR_PCH_8CTAP <class 'cicpy.core.layoutcell.LayoutCell'>
*-------------------------------------------------------------
.SUBCKT JNWATR_PCH_8CTAP
.ENDS

*-------------------------------------------------------------
* JNWATR_PCH_8C5F0 <class 'cicpy.core.layoutcell.LayoutCell'>
*-------------------------------------------------------------
.SUBCKT JNWATR_PCH_8C5F0 D G S B
M1 D G S B sky130_fd_pr__pfet_01v8  l=0.94  nf=2  w=2.88
.ENDS

*-------------------------------------------------------------
* JNWATR_PCH_8CTOP <class 'cicpy.core.layoutcell.LayoutCell'>
*-------------------------------------------------------------
.SUBCKT JNWATR_PCH_8CTOP
xa1  JNWATR_PCH_8CTAP
xa2 D G S B JNWATR_PCH_8C1F2
xa3 D G S B JNWATR_PCH_8C5F0
xa4  JNWATR_PCH_8CTAP
.ENDS

*-------------------------------------------------------------
* JNWATR_PCH_12C1F2 <class 'cicpy.core.layoutcell.LayoutCell'>
*-------------------------------------------------------------
.SUBCKT JNWATR_PCH_12C1F2 D G S B
M1 D G S B sky130_fd_pr__pfet_01v8  l=0.22  nf=2  w=4.16
.ENDS

*-------------------------------------------------------------
* JNWATR_PCH_12CTAP <class 'cicpy.core.layoutcell.LayoutCell'>
*-------------------------------------------------------------
.SUBCKT JNWATR_PCH_12CTAP
.ENDS

*-------------------------------------------------------------
* JNWATR_PCH_12C5F0 <class 'cicpy.core.layoutcell.LayoutCell'>
*-------------------------------------------------------------
.SUBCKT JNWATR_PCH_12C5F0 D G S B
M1 D G S B sky130_fd_pr__pfet_01v8  l=0.94  nf=2  w=4.16
.ENDS

*-------------------------------------------------------------
* JNWATR_PCH_12CTOP <class 'cicpy.core.layoutcell.LayoutCell'>
*-------------------------------------------------------------
.SUBCKT JNWATR_PCH_12CTOP
xa1  JNWATR_PCH_12CTAP
xa2 D G S B JNWATR_PCH_12C1F2
xa3 D G S B JNWATR_PCH_12C5F0
xa4  JNWATR_PCH_12CTAP
.ENDS

*-------------------------------------------------------------
* JNWATR_NCH_2C1F2 <class 'cicpy.core.layoutcell.LayoutCell'>
*-------------------------------------------------------------
.SUBCKT JNWATR_NCH_2C1F2 D G S B
M1 D G S B sky130_fd_pr__nfet_01v8  l=0.22  nf=2  w=0.96
.ENDS

*-------------------------------------------------------------
* JNWATR_NCH_2CTAP <class 'cicpy.core.layoutcell.LayoutCell'>
*-------------------------------------------------------------
.SUBCKT JNWATR_NCH_2CTAP
.ENDS

*-------------------------------------------------------------
* JNWATR_NCH_2C5F0 <class 'cicpy.core.layoutcell.LayoutCell'>
*-------------------------------------------------------------
.SUBCKT JNWATR_NCH_2C5F0 D G S B
M1 D G S B sky130_fd_pr__nfet_01v8  l=0.94  nf=2  w=0.96
.ENDS

*-------------------------------------------------------------
* JNWATR_NCH_2CTOP <class 'cicpy.core.layoutcell.LayoutCell'>
*-------------------------------------------------------------
.SUBCKT JNWATR_NCH_2CTOP
xa1  JNWATR_NCH_2CTAP
xa2 D G S B JNWATR_NCH_2C1F2
xa3 D G S B JNWATR_NCH_2C5F0
xa4  JNWATR_NCH_2CTAP
.ENDS

*-------------------------------------------------------------
* JNWATR_NCH_4C1F2 <class 'cicpy.core.layoutcell.LayoutCell'>
*-------------------------------------------------------------
.SUBCKT JNWATR_NCH_4C1F2 D G S B
M1 D G S B sky130_fd_pr__nfet_01v8  l=0.22  nf=2  w=1.6
.ENDS

*-------------------------------------------------------------
* JNWATR_NCH_4CTAP <class 'cicpy.core.layoutcell.LayoutCell'>
*-------------------------------------------------------------
.SUBCKT JNWATR_NCH_4CTAP
.ENDS

*-------------------------------------------------------------
* JNWATR_NCH_4C5F0 <class 'cicpy.core.layoutcell.LayoutCell'>
*-------------------------------------------------------------
.SUBCKT JNWATR_NCH_4C5F0 D G S B
M1 D G S B sky130_fd_pr__nfet_01v8  l=0.94  nf=2  w=1.6
.ENDS

*-------------------------------------------------------------
* JNWATR_NCH_4CTOP <class 'cicpy.core.layoutcell.LayoutCell'>
*-------------------------------------------------------------
.SUBCKT JNWATR_NCH_4CTOP
xa1  JNWATR_NCH_4CTAP
xa2 D G S B JNWATR_NCH_4C1F2
xa3 D G S B JNWATR_NCH_4C5F0
xa4  JNWATR_NCH_4CTAP
.ENDS

*-------------------------------------------------------------
* JNWATR_NCH_8C1F2 <class 'cicpy.core.layoutcell.LayoutCell'>
*-------------------------------------------------------------
.SUBCKT JNWATR_NCH_8C1F2 D G S B
M1 D G S B sky130_fd_pr__nfet_01v8  l=0.22  nf=2  w=2.88
.ENDS

*-------------------------------------------------------------
* JNWATR_NCH_8CTAP <class 'cicpy.core.layoutcell.LayoutCell'>
*-------------------------------------------------------------
.SUBCKT JNWATR_NCH_8CTAP
.ENDS

*-------------------------------------------------------------
* JNWATR_NCH_8C5F0 <class 'cicpy.core.layoutcell.LayoutCell'>
*-------------------------------------------------------------
.SUBCKT JNWATR_NCH_8C5F0 D G S B
M1 D G S B sky130_fd_pr__nfet_01v8  l=0.94  nf=2  w=2.88
.ENDS

*-------------------------------------------------------------
* JNWATR_NCH_8CTOP <class 'cicpy.core.layoutcell.LayoutCell'>
*-------------------------------------------------------------
.SUBCKT JNWATR_NCH_8CTOP
xa1  JNWATR_NCH_8CTAP
xa2 D G S B JNWATR_NCH_8C1F2
xa3 D G S B JNWATR_NCH_8C5F0
xa4  JNWATR_NCH_8CTAP
.ENDS

*-------------------------------------------------------------
* JNWATR_NCH_12C1F2 <class 'cicpy.core.layoutcell.LayoutCell'>
*-------------------------------------------------------------
.SUBCKT JNWATR_NCH_12C1F2 D G S B
M1 D G S B sky130_fd_pr__nfet_01v8  l=0.22  nf=2  w=4.16
.ENDS

*-------------------------------------------------------------
* JNWATR_NCH_12CTAP <class 'cicpy.core.layoutcell.LayoutCell'>
*-------------------------------------------------------------
.SUBCKT JNWATR_NCH_12CTAP
.ENDS

*-------------------------------------------------------------
* JNWATR_NCH_12C5F0 <class 'cicpy.core.layoutcell.LayoutCell'>
*-------------------------------------------------------------
.SUBCKT JNWATR_NCH_12C5F0 D G S B
M1 D G S B sky130_fd_pr__nfet_01v8  l=0.94  nf=2  w=4.16
.ENDS

*-------------------------------------------------------------
* JNWATR_NCH_12CTOP <class 'cicpy.core.layoutcell.LayoutCell'>
*-------------------------------------------------------------
.SUBCKT JNWATR_NCH_12CTOP
xa1  JNWATR_NCH_12CTAP
xa2 D G S B JNWATR_NCH_12C1F2
xa3 D G S B JNWATR_NCH_12C5F0
xa4  JNWATR_NCH_12CTAP
.ENDS
